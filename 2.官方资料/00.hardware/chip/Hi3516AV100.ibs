|   IBIS model for hi3516av100
[IBIS ver]   4.1
[Comment char]  |_char
[File name]   hi3516av100.ibs
[File Rev]   1.0
[Date]   7,23,2014
[Source]   HISILICON TECHNOLOGIES CO., LTD.
[Notes]
|[Disclaimer]   HISILICON TECHNOLOGIES CO., LTD. hereby grants the
| *   user of this IBIS model a non-exclusive, nontransferable
|*   license to use this IBIS model under the following terms.
|*   The user is granted this license only to use the IBIS model
|*   and is not granted rights to sell, copy (except as needed to
|*   run the IBIS model), rent, lease or sub-license the IBIS
|*   model in whole or in part, or in modified form to anyone. The
|*   User may modify the IBIS model to suit its specific applicati
|*   ons, but rights to derivative works and such modifications sh
|*   all belong to Hisilicon. This IBIS model is provided on an
|*   "ASIS" basis and Hisilicon  makes absolutely no warranty with
|*   respect to the information contained herein. HISILICON DISCLAI
|*   MS AND CUSTOMER WAIVES ALL WARRANTIES, EXPRESS AND IMPLIED, IN
|*   CLUDING WARRANTIES OF MERCHANTABILITY AND FITNESS FOR A PARTIC
|*   ULAR PURPOSE. THE ENTIRE RISK AS TO QUALITY AND PERFORMANCE IS
|*   WITH THE USER ACCORDINGLY, IN NO EVENT SHALL HISILICON BE LIAB
|*   LE FOR ANY DIRECT OR INDIRECT DAMAGES, WHETHER IN CONTRACT OR
|*   TORT, INCLUDING ANY LOST PROFITS OR OTHER INCIDENTAL, CONSEQUEN
|*   TIAL, EXEMPLARY, OR PUNITIVE DAMAGES ARISING OUT OF THE USE OR
|*   APPLICATION OF THE IBIS MODEL. Further, Hisilicon reserves the
|*   right to make changes without notice to any product herein to
|*   improve reliability,fnction, or design. Hisilicon does not convey
|*   any license under patent rights or any other intellectual property
|*   rights, including those of third parties. Hisilicon is not obligated
|*   to provide maintenance or support for the licensed IBIS model.
|*[Copyright]  Copyright 2013,HISILICON TECHNOLOGIES CO., LTD.
|*   all rights reserved
|*Author   :  Hisilicon *****/
||****************************************************************************/
|   IBIS model for hi3516av100
|   Component hi3516av100
[Component]   hi3516av100
[Manufacturer]   hisi inc.
[Package]
| variable   typ   min   max
R_pkg   550mohm   500mohm   600mohm
L_pkg   5nH   3nH   6nH
C_pkg   2.0pF   1.5pF   2.5pF
[Pin]   signal_name   model_name   R_pin   L_pin   C_pin
Y6   VI_DAT14   PRDW4DCDG_L
W5   VI_DAT13   PRDW4DCDG_L
Y5   VI_DAT12   PRDW4DCDG_L
W8   VI_DAT11   PRDW4DCDG_L
Y4   VI_DAT10   PRDW4DCDG_L
Y7   VI_DAT9   PRDW4DCDG_L
AB8   VI_DAT8   PRDW4DCDG_L
W7   VI_DAT7   PRDW4DCDG_L
AB6   VI_DAT5   PRDW4DCDG_L
AB7   VI_DAT6   PRDW4DCDG_L
AA5   VI_DAT4   PRDW4DCDG_L
AB5   VI_DAT3   PRDW4DCDG_L
AA4   VI_DAT2   PRDW4DCDG_L
AB4   VI_DAT1   PRDW4DCDG_L
AA3   VI_DAT0   PRDW4DCDG_L
AA7   VI_CLK   PRDW4DCDG_L
W4   VI_HS   PRDW4DCDG_L
AB3   VI_VS   PRDW4DCDG_L
W6   VI_DAT15   PRDW4DCDG_L
Y2   SPI0_SDO   PRUW4DSCDG_L
AB2   SPI0_SCLK   PRUW8DSCDG
AA2   SPI0_SDI   PRDW4DCDG_L
Y3   SPI0_CSN   PRDW4DCDG_L
Y17   SPI1_CSN   PRDW4DCDG_L
Y16   SPI1_SDO   PRUW4DSCDG_L
W16   SPI1_SDI   PRDW4DCDG_L
AA16   SPI1_SCLK   PRUW4DSCDG_L
Y21   UART0_TXD   PRDW4DDGZ_L
W21   UART0_RXD   PRUW4DDGZ_L
Y19   UART1_RTSN   PRUW4DCDG_L
Y22   UART1_RXD   PRUW4DCDG_L
W22   UART1_TXD   PRDW4DCDG_L
W20   UART1_CTSN   PRDW4DCDG_L
AA17   UART2_RXD   PRUW4DCDG_L
V22   UART2_TXD   PRDW4DCDG_L
AB21   I2C2_SCL   PRUW4DSCDG_L
AA20   I2C2_SDA   PRUW4DSCDG_L
M21   SDIO0_CDATA3   PRDW8DCDG
M19   SDIO0_CDATA0   PRDW8DCDG
M20   SDIO0_CCMD   PRDW8DCDG
L22   SDIO0_CCLK_OUT   PRDW8DCDG
L21   SDIO0_CDATA1   PRDW8DCDG
L20   SDIO0_CDATA2   PRDW8DCDG
N19   SDIO0_CARD_DETECT   PRDW4DSCDG_L
N20   SDIO0_CARD_POWER_EN   PRDW4DCDG_L
M22   SDIO0_CWPR   PRDW4DCDG_L
J21   SDIO1_CARD_POWER_EN   PRDW4DCDG_L
J20   SDIO1_CARD_DETECT   PRDW4DSCDG_L
J19   SDIO1_CWPR   PRDW4DCDG_L
L19   SDIO1_CDATA2   PRDW8DCDG
J22   SDIO1_CDATA1   PRDW8DCDG
K21   SDIO1_CCMD   PRDW8DCDG
K22   SDIO1_CCLK_OUT   PRDW8DCDG
K20   SDIO1_CDATA0   PRDW8DCDG
K19   SDIO1_CDATA3   PRDW8DCDG
E22   VO_DAT9   PRDW4DCDG_L
H21   VO_DAT2   PRDW4DSCDG_L
F19   VO_DAT8   PRDW4DSCDG_L
G22   VO_CLK   PRDW8DCDG
H20   VO_DAT0   PRDW4DSCDG_L
H19   VO_DAT1   PRDW4DSCDG_L
G19   VO_DAT3   PRDW4DCDG_L
G21   VO_DAT4   PRDW4DCDG_L
D21   VO_DAT13   PRDW4DCDG_L
F20   VO_DAT10   PRDW4DCDG_L
E21   VO_DAT11   PRDW4DCDG_L
D22   VO_DAT12   PRDW4DCDG_L
G20   VO_DAT6   PRDW4DCDG_L
F22   VO_DAT5   PRDW4DCDG_L
E20   VO_DAT14   PRDW4DCDG_L
C22   VO_DAT15   PRDW4DCDG_L
F21   VO_DAT7   PRDW4DCDG_L
D19   RGMII_TXD3   PRDW8DCDG_H
C20   RGMII_TXD2   PRDW8DCDG_H
C21   RGMII_TXD1   PRDW8DCDG_H
B21   RGMII_TXD0   PRDW8DCDG_H
B22   RGMII_TX_CLK   PRDW8DCDG_H
A20   RGMII_RXD3   PRDW4DCDG_L
A21   RGMII_RX_CLK   PRDW4DCDG_L
C19   RGMII_TX_EN   PRDW8DCDG_H
C18   RGMII_RXD1   PRDW4DCDG_L
A19   RGMII_RXD2   PRDW4DCDG_L
A18   RGMII_RXD0   PRDW4DCDG_L
B18   RGMII_RX_DV   PRDW4DCDG_L
E19   EPHY_CLK   PRDW8DCDG
B19   MDCK   PRDW8DCDG
D18   MDIO   PRDW8DCDG
N4   NF_DQ7   PRDW4DCDG_L
M4   NF_DQ6   PRDW4DCDG_L
K1   NF_RDY0   PRUW4DSCDG_L
M3   NF_DQ5   PRDW4DCDG_L
L3   NF_DQ4   PRDW4DCDG_L
K2   NF_RDY1   PRUW4DSCDG_L
L1   NF_CSN0   PRDW4DCDG_L
K3   NF_DQ3   PRDW4DCDG_L
K4   NF_DQ2   PRDW4DCDG_L
M1   NF_CLE   PRDW4DSCDG_L
L2   NF_REN   PRUW4DSCDG_L
L4   NF_DQ1   PRDW4DCDG_L
N3   NF_DQ0   PRDW4DCDG_L
M2   NF_CSN1   PRDW4DCDG_L
N2   NF_ALE   PRDW4DSCDG_L
N1   NF_WEN   PRDW4DSCDG_L
P3   SFC_SOI_IO1   PRDW4DCDG_L
P2   SFC_WP_IO2   PRDW4DCDG_L
P1   SFC_CLK   PRDW4DSCDG_L
R4   SFC_HOLD_IO3   PRDW4DCDG_L
R3   SFC_CSN   PRDW4DCDG_L
R2   SFC_SIO_IO0   PRDW4DCDG_L
Y1   GPIO0_0   PRDW4DCDG_L
AB16   GPIO0_3   PRDW4DCDG_L
AB18   GPIO0_2   PRDW4DCDG_L
Y20   GPIO0_4   PRDW4DCDG_L
D20   GPIO0_1   PRDW8DCDG
E4   DDR3_DQ19   PDDRSIO_ISOG
H3   DDR3_DM2   PDDRSIO_ISOG
H2   DDR3_DQ28   PDDRSIO_ISOG
E3   DDR3_DQ21   PDDRSIO_ISOG
H1   DDR3_DQ30   PDDRSIO_ISOG
D2   DDR3_DQ23   PDDRSIO_ISOG
J1   DDR3_DQ26   PDDRSIO_ISOG
D3   DDR3_DQ17   PDDRSIO_ISOG
J4   DDR3_DQ29   PDDRSIO_ISOG
G4   DDR3_DQ31   PDDRSIO_ISOG
F3   DDR3_DQ18   PDDRSIO_ISOG
G2   DDR3_DQS3_P   PDDRDIO_ISOG
C2   DDR3_DQ20   PDDRSIO_ISOG
D1   DDR3_DQ25   PDDRSIO_ISOG
E1   DDR3_DQS2_P   PDDRDIO_ISOG
G3   DDR3_DQ16   PDDRSIO_ISOG
H4   DDR3_DQ27   PDDRSIO_ISOG
C1   DDR3_DQ22   PDDRSIO_ISOG
J3   DDR3_DQ24   PDDRSIO_ISOG
F4   DDR3_DM3   PDDRSIO_ISOG
A8   DDR3_CLK1_P   PDDRDIO_ISOG
B10   DDR3_CLK0_P   PDDRDIO_ISOG
A3   DDR3_BA0   PDDRSIO_ISOG
B3   DDR3_RAS_N   PDDRSIO_ISOG
A5   DDR3_A7   PDDRSIO_ISOG
A2   DDR3_CAS_N   PDDRSIO_ISOG
D10   DDR3_ODT_0   PDDRSIO_ISOG
B4   DDR3_A3   PDDRSIO_ISOG
A4   DDR3_A5   PDDRSIO_ISOG
C8   DDR3_CS0_N   PDDRSIO_ISOG
B2   DDR3_ODT_1   PDDRSIO_ISOG
C4   DDR3_WE_N   PDDRSIO_ISOG
B7   DDR3_A13   PDDRSIO_ISOG
A7   DDR3_A0   PDDRSIO_ISOG
B5   DDR3_A2   PDDRSIO_ISOG
D8   DDR3_BA2   PDDRSIO_ISOG
A6   DDR3_A9   PDDRSIO_ISOG
B6   DDR3_RESET_N   PDDRSIO_ISOG
C7   DDR3_A12   PDDRSIO_ISOG
C5   DDR3_A1   PDDRSIO_ISOG
C6   DDR3_A10   PDDRSIO_ISOG
D9   DDR3_BA1   PDDRSIO_ISOG
D5   DDR3_A14   PDDRSIO_ISOG
C3   DDR3_A6   PDDRSIO_ISOG
D6   DDR3_A11   PDDRSIO_ISOG
D4   DDR3_A8   PDDRSIO_ISOG
C9   DDR3_A4   PDDRSIO_ISOG
B1   DDR3_CS1_N   PDDRSIO_ISOG
D7   DDR3_CKE   PDDRSIO_ISOG
C14   DDR3_DQ4   PDDRSIO_ISOG
D13   DDR3_DM1   PDDRSIO_ISOG
A17   DDR3_DQ6   PDDRSIO_ISOG
C15   DDR3_DQ9   PDDRSIO_ISOG
C13   DDR3_DQ2   PDDRSIO_ISOG
D15   DDR3_DQ11   PDDRSIO_ISOG
D11   DDR3_DQ7   PDDRSIO_ISOG
C10   DDR3_DQ5   PDDRSIO_ISOG
B15   DDR3_DQS0_P   PDDRDIO_ISOG
D16   DDR3_DQ15   PDDRSIO_ISOG
B13   DDR3_DQS1_P   PDDRDIO_ISOG
B16   DDR3_DQ12   PDDRSIO_ISOG
A16   DDR3_DQ0   PDDRSIO_ISOG
D14   DDR3_DQ14   PDDRSIO_ISOG
C16   DDR3_DQ13   PDDRSIO_ISOG
B12   DDR3_DM0   PDDRSIO_ISOG
D12   DDR3_DQ1   PDDRSIO_ISOG
A12   DDR3_DQ10   PDDRSIO_ISOG
C12   DDR3_DQ8   PDDRSIO_ISOG
C11   DDR3_DQ3   PDDRSIO_ISOG
|   Model Selector
[Model Selector] PDDRDIO_ISOG
hi_drv3_3420   Driving, Z0=34-Ohms, Rload=20-Ohms
hi_drv3_3430   Driving, Z0=34-Ohms, Rload=30-Ohms
hi_drv3_3440   Driving, Z0=34-Ohms, Rload=40-Ohms
hi_drv3_3460   Driving, Z0=34-Ohms, Rload=60-Ohms
hi_drv3_34120   Driving, Z0=34-Ohms, Rload=120-Ohms
hi_drv3_4020   Driving, Z0=40-Ohms, Rload=20-Ohms
hi_drv3_4030   Driving, Z0=40-Ohms, Rload=30-Ohms
hi_drv3_4040   Driving, Z0=40-Ohms, Rload=40-Ohms
hi_drv3_4060   Driving, Z0=40-Ohms, Rload=60-Ohms
hi_drv3_40120   Driving, Z0=40-Ohms, Rload=120-Ohms
hi_drv3_6020   Driving, Z0=60-Ohms, Rload=20-Ohms
hi_drv3_6030   Driving, Z0=60-Ohms, Rload=30-Ohms
hi_drv3_6040   Driving, Z0=60-Ohms, Rload=40-Ohms
hi_drv3_6060   Driving, Z0=60-Ohms, Rload=60-Ohms
hi_drv3_60120   Driving, Z0=60-Ohms, Rload=120-Ohms
hi_rcv3_odt20   Receiving, ODT=20-Ohms
hi_rcv3_odt30   Receiving, ODT=30-Ohms
hi_rcv3_odt40   Receiving, ODT=40-Ohms
hi_rcv3_odt60   Receiving, ODT=60-Ohms
hi_rcv3_odt120   Receiving, ODT=120-Ohms
hi_rcv3_odtoff   Receiving, ODT=OFF
|   Model Selector
[Model Selector] PDDRSIO_ISOG
hi_drv3_3420   Driving, Z0=34-Ohms, Rload=20-Ohms
hi_drv3_3430   Driving, Z0=34-Ohms, Rload=30-Ohms
hi_drv3_3440   Driving, Z0=34-Ohms, Rload=40-Ohms
hi_drv3_3460   Driving, Z0=34-Ohms, Rload=60-Ohms
hi_drv3_34120   Driving, Z0=34-Ohms, Rload=120-Ohms
hi_drv3_4020   Driving, Z0=40-Ohms, Rload=20-Ohms
hi_drv3_4030   Driving, Z0=40-Ohms, Rload=30-Ohms
hi_drv3_4040   Driving, Z0=40-Ohms, Rload=40-Ohms
hi_drv3_4060   Driving, Z0=40-Ohms, Rload=60-Ohms
hi_drv3_40120   Driving, Z0=40-Ohms, Rload=120-Ohms
hi_drv3_6020   Driving, Z0=60-Ohms, Rload=20-Ohms
hi_drv3_6030   Driving, Z0=60-Ohms, Rload=30-Ohms
hi_drv3_6040   Driving, Z0=60-Ohms, Rload=40-Ohms
hi_drv3_6060   Driving, Z0=60-Ohms, Rload=60-Ohms
hi_drv3_60120   Driving, Z0=60-Ohms, Rload=120-Ohms
hi_rcv3_odt20   Receiving, ODT=20-Ohms
hi_rcv3_odt30   Receiving, ODT=30-Ohms
hi_rcv3_odt40   Receiving, ODT=40-Ohms
hi_rcv3_odt60   Receiving, ODT=60-Ohms
hi_rcv3_odt120   Receiving, ODT=120-Ohms
hi_rcv3_odtoff   Receiving, ODT=OFF
|   Model Selector
[Model Selector] PRDW4DCDG_L
| Model Description
M0_io_3V3_4driver_1ma   when DS1 & DS0
M1_io_3V3_4driver_2ma   when DS1 & !DS0
M2_io_3V3_4driver_3ma   when !DS1 & DS0
M3_io_3V3_4driver_4ma   when !DS1 & !DS0
|   Model Selector
[Model Selector] PRDW4DSCDG_L
| Model Description
M0_io_3V3_4driver_1ma   when DS1 & DS0
M1_io_3V3_4driver_2ma   when DS1 & !DS0
M2_io_3V3_4driver_3ma   when !DS1 & DS0
M3_io_3V3_4driver_4ma   when !DS1 & !DS0
|   Model Selector
[Model Selector] PRDW4DDGZ_L
| Model Description
M0_io_3V3_4driver_1ma   when DS1 & DS0
M1_io_3V3_4driver_2ma   when DS1 & !DS0
M2_io_3V3_4driver_3ma   when !DS1 & DS0
M3_io_3V3_4driver_4ma   when !DS1 & !DS0
|   Model Selector
[Model Selector] PRUW4DCDG_L
| Model Description
M0_io_3V3_4driver_1ma   when DS1 & DS0
M1_io_3V3_4driver_2ma   when DS1 & !DS0
M2_io_3V3_4driver_3ma   when !DS1 & DS0
M3_io_3V3_4driver_4ma   when !DS1 & !DS0
|   Model Selector
[Model Selector] PRUW4DDGZ_L
| Model Description
M0_io_3V3_4driver_1ma   when DS1 & DS0
M1_io_3V3_4driver_2ma   when DS1 & !DS0
M2_io_3V3_4driver_3ma   when !DS1 & DS0
M3_io_3V3_4driver_4ma   when !DS1 & !DS0
|   Model Selector
[Model Selector] PRUW4DSCDG_L
| Model Description
M0_io_3V3_4driver_1ma   when DS1 & DS0
M1_io_3V3_4driver_2ma   when DS1 & !DS0
M2_io_3V3_4driver_3ma   when !DS1 & DS0
M3_io_3V3_4driver_4ma   when !DS1 & !DS0
|   Model Selector
[Model Selector] PRUW8DSCDG
| Model Description
M0_io_1V8_8driver_1ma   when DS2 & DS1 & DS0
M1_io_1V8_8driver_2ma   when DS2 & DS1 & !DS0
M2_io_1V8_8driver_4ma   when DS2 & !DS1 & DS0
M3_io_1V8_8driver_5ma   when DS2 & !DS1 & !DS0
M4_io_1V8_8driver_8ma   when !DS2 & DS1 & DS0
M5_io_1V8_8driver_9ma   when !DS2 & DS1 & !DS0
M6_io_1V8_8driver_11ma   when !DS2 & !DS1 & DS0
M7_io_1V8_8driver_12ma   when !DS2 & !DS1 & !DS0
M0_io_2V5_8driver_1ma   when DS2 & DS1 & DS0
M1_io_2V5_8driver_2ma   when DS2 & DS1 & !DS0
M2_io_2V5_8driver_4ma   when DS2 & !DS1 & DS0
M3_io_2V5_8driver_5ma   when DS2 & !DS1 & !DS0
M4_io_2V5_8driver_8ma   when !DS2 & DS1 & DS0
M5_io_2V5_8driver_9ma   when !DS2 & DS1 & !DS0
M6_io_2V5_8driver_11ma   when !DS2 & !DS1 & DS0
M7_io_2V5_8driver_12ma   when !DS2 & !DS1 & !DS0
M0_io_3V3_8driver_1ma   when DS2 & DS1 & DS0
M1_io_3V3_8driver_2ma   when DS2 & DS1 & !DS0
M2_io_3V3_8driver_4ma   when DS2 & !DS1 & DS0
M3_io_3V3_8driver_5ma   when DS2 & !DS1 & !DS0
M4_io_3V3_8driver_8ma   when !DS2 & DS1 & DS0
M5_io_3V3_8driver_9ma   when !DS2 & DS1 & !DS0
M6_io_3V3_8driver_11ma   when !DS2 & !DS1 & DS0
M7_io_3V3_8driver_12ma   when !DS2 & !DS1 & !DS0
|   Model Selector
[Model Selector] PRDW8DCDG
| Model Description
M0_io_1V8_8driver_1ma   when DS2 & DS1 & DS0
M1_io_1V8_8driver_2ma   when DS2 & DS1 & !DS0
M2_io_1V8_8driver_4ma   when DS2 & !DS1 & DS0
M3_io_1V8_8driver_5ma   when DS2 & !DS1 & !DS0
M4_io_1V8_8driver_8ma   when !DS2 & DS1 & DS0
M5_io_1V8_8driver_9ma   when !DS2 & DS1 & !DS0
M6_io_1V8_8driver_11ma   when !DS2 & !DS1 & DS0
M7_io_1V8_8driver_12ma   when !DS2 & !DS1 & !DS0
M0_io_2V5_8driver_1ma   when DS2 & DS1 & DS0
M1_io_2V5_8driver_2ma   when DS2 & DS1 & !DS0
M2_io_2V5_8driver_4ma   when DS2 & !DS1 & DS0
M3_io_2V5_8driver_5ma   when DS2 & !DS1 & !DS0
M4_io_2V5_8driver_8ma   when !DS2 & DS1 & DS0
M5_io_2V5_8driver_9ma   when !DS2 & DS1 & !DS0
M6_io_2V5_8driver_11ma   when !DS2 & !DS1 & DS0
M7_io_2V5_8driver_12ma   when !DS2 & !DS1 & !DS0
M0_io_3V3_8driver_1ma   when DS2 & DS1 & DS0
M1_io_3V3_8driver_2ma   when DS2 & DS1 & !DS0
M2_io_3V3_8driver_4ma   when DS2 & !DS1 & DS0
M3_io_3V3_8driver_5ma   when DS2 & !DS1 & !DS0
M4_io_3V3_8driver_8ma   when !DS2 & DS1 & DS0
M5_io_3V3_8driver_9ma   when !DS2 & DS1 & !DS0
M6_io_3V3_8driver_11ma   when !DS2 & !DS1 & DS0
M7_io_3V3_8driver_12ma   when !DS2 & !DS1 & !DS0
|   Model Selector
[Model Selector] PRDW8DCDG_H
| Model Description
M0_io4_1V8_8driver_1ma   when DS2 & DS1 & DS0
M1_io4_1V8_8driver_2ma   when DS2 & DS1 & !DS0
M2_io4_1V8_8driver_4ma   when DS2 & !DS1 & DS0
M3_io4_1V8_8driver_5ma   when DS2 & !DS1 & !DS0
M4_io4_1V8_8driver_12ma   when !DS2 & DS1 & DS0
M5_io4_1V8_8driver_14ma   when !DS2 & DS1 & !DS0
M6_io4_1V8_8driver_16ma   when !DS2 & !DS1 & DS0
M7_io4_1V8_8driver_18ma   when !DS2 & !DS1 & !DS0
M0_io4_2V5_8driver_1ma   when DS2 & DS1 & DS0
M1_io4_2V5_8driver_2ma   when DS2 & DS1 & !DS0
M2_io4_2V5_8driver_4ma   when DS2 & !DS1 & DS0
M3_io4_2V5_8driver_5ma   when DS2 & !DS1 & !DS0
M4_io4_2V5_8driver_12ma   when !DS2 & DS1 & DS0
M5_io4_2V5_8driver_14ma   when !DS2 & DS1 & !DS0
M6_io4_2V5_8driver_16ma   when !DS2 & !DS1 & DS0
M7_io4_2V5_8driver_18ma   when !DS2 & !DS1 & !DS0
M0_io4_3V3_8driver_1ma   when DS2 & DS1 & DS0
M1_io4_3V3_8driver_2ma   when DS2 & DS1 & !DS0
M2_io4_3V3_8driver_4ma   when DS2 & !DS1 & DS0
M3_io4_3V3_8driver_5ma   when DS2 & !DS1 & !DS0
M4_io4_3V3_8driver_12ma   when !DS2 & DS1 & DS0
M5_io4_3V3_8driver_14ma   when !DS2 & DS1 & !DS0
M6_io4_3V3_8driver_16ma   when !DS2 & !DS1 & DS0
M7_io4_3V3_8driver_18ma   when !DS2 & !DS1 & !DS0
| Models and submodels in the file (73): hi_drv3_34120 (I/O), hi_drv3_3420 (I/O), hi_drv3_3430 (I/O), hi_drv3_3440 (I/O), hi_drv3_3460 (I/O), hi_drv3_40120 (I/O), hi_drv3_4020 (I/O), hi_drv3_4030 (I/O), hi_drv3_4040 (I/O), hi_drv3_4060 (I/O), hi_drv3_60120 (I/O), hi_drv3_6020 (I/O), hi_drv3_6030 (I/O), hi_drv3_6040 (I/O), hi_drv3_6060 (I/O), hi_rcv3_odt120 (Input), hi_rcv3_odt20 (Input), hi_rcv3_odt30 (Input), hi_rcv3_odt40 (Input), hi_rcv3_odt60 (Input), hi_rcv3_odtoff (Input), M0_io_3V3_4driver_1ma (I/O), M1_io_3V3_4driver_2ma (I/O), M2_io_3V3_4driver_3ma (I/O), M3_io_3V3_4driver_4ma (I/O), M0_io_1V8_8driver_1ma (I/O), M1_io_1V8_8driver_2ma (I/O), M2_io_1V8_8driver_4ma (I/O), M3_io_1V8_8driver_5ma (I/O), M4_io_1V8_8driver_8ma (I/O), M5_io_1V8_8driver_9ma (I/O), M6_io_1V8_8driver_11ma (I/O), M7_io_1V8_8driver_12ma (I/O), M0_io_2V5_8driver_1ma (I/O), M1_io_2V5_8driver_2ma (I/O), M2_io_2V5_8driver_4ma (I/O), M3_io_2V5_8driver_5ma (I/O), M4_io_2V5_8driver_8ma (I/O), M5_io_2V5_8driver_9ma (I/O), M6_io_2V5_8driver_11ma (I/O), M7_io_2V5_8driver_12ma (I/O), M0_io_3V3_8driver_1ma (I/O), M1_io_3V3_8driver_2ma (I/O), M2_io_3V3_8driver_4ma (I/O), M3_io_3V3_8driver_5ma (I/O), M4_io_3V3_8driver_8ma (I/O), M5_io_3V3_8driver_9ma (I/O), M6_io_3V3_8driver_11ma (I/O), M7_io_3V3_8driver_12ma (I/O), M0_io4_1V8_8driver_1ma (I/O), M1_io4_1V8_8driver_2ma (I/O), M2_io4_1V8_8driver_4ma (I/O), M3_io4_1V8_8driver_5ma (I/O), M4_io4_1V8_8driver_12ma (I/O), M5_io4_1V8_8driver_14ma (I/O), M6_io4_1V8_8driver_16ma (I/O), M7_io4_1V8_8driver_18ma (I/O), M0_io4_2V5_8driver_1ma (I/O), M1_io4_2V5_8driver_2ma (I/O), M2_io4_2V5_8driver_4ma (I/O), M3_io4_2V5_8driver_5ma (I/O), M4_io4_2V5_8driver_12ma (I/O), M5_io4_2V5_8driver_14ma (I/O), M6_io4_2V5_8driver_16ma (I/O), M7_io4_2V5_8driver_18ma (I/O), M0_io4_3V3_8driver_1ma (I/O), M1_io4_3V3_8driver_2ma (I/O), M2_io4_3V3_8driver_4ma (I/O), M3_io4_3V3_8driver_5ma (I/O), M4_io4_3V3_8driver_12ma (I/O), M5_io4_3V3_8driver_14ma (I/O), M6_io4_3V3_8driver_16ma (I/O), M7_io4_3V3_8driver_18ma (I/O)
